* Full sequence: latched off -> WAKE -> inrush into 100uF||2R -> overload (~9A demand) -> limit ~4.9A
* -> CT timeout -> FAULT latched off -> overload removed -> WAKE restart -> GPIO OFF pulse -> latched off
.lib /foss/pdks/sky130A/libs.tech/ngspice/sky130.lib.spice tt
.include /foss/pdks/sky130A/libs.ref/sky130_fd_sc_hvl/spice/sky130_fd_sc_hvl.spice
.include ../spice/ls_core.spice
.include models/ext.lib
.include ext_circuit.spice
.param CF=1n CT=10n
.option method=gear reltol=1e-3
VSUP VS 0 5.1
RSUP VS VSL 10m
LSUP VSL VIN 1u
CIN VIN 0 470u
VA VAPWR 0 3.3
VD VDPWR 0 1.8
VOFF OFF 0 PWL(0 1.8 0.5m 1.8 0.501m 0 36m 0 36.001m 1.8 36.2m 1.8 36.201m 0)
VWAKE WAKE 0 PWL(0 0 1m 0 1.001m 1.8 1.1m 1.8 1.101m 0 30m 0 30.001m 1.8 30.1m 1.8 30.101m 0)
VRST RSTN 0 1.8
XC VAPWR VDPWR 0 SNS_A SNS_B GATE CT OFF WAKE RSTN PWR_ON ILIM FAULT ls_core
XE VIN OUT SNS_A SNS_B GATE CT ext_hw
CL OUT CLE 100u
RCLE CLE 0 30m
RL OUT 0 2
SOV OUT OVL OVC 0 SW1
ROV OVL 0 0.8
VOVC OVC 0 PWL(0 0 8m 0 8.001m 1 28m 1 28.001m 0)
.model SW1 SW vt=0.5 vh=0.1 ron=1m roff=1e9
.control
tran 1u 40m 0 2u
let iload = i(VSUP)*-1
wrdata tb_seq.txt v(OUT) iload v(GATE) v(CT) v(PWR_ON) v(ILIM) v(FAULT) v(xe.pg) v(xc.det) v(xc.out1)
.endc
.end
