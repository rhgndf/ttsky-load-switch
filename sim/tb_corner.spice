* overload step at corner CORNER / temp / VAPWR (substituted by run_corners.sh)
.lib /foss/pdks/sky130A/libs.tech/ngspice/sky130.lib.spice @CORNER@
.include /foss/pdks/sky130A/libs.ref/sky130_fd_sc_hvl/spice/sky130_fd_sc_hvl.spice
.include ../spice/ls_core.spice
.include models/ext.lib
.include ext_circuit.spice
.param CF=1n CT=10n
.temp @TEMP@
.option method=gear reltol=1e-3
VSUP VS 0 5.1
RSUP VS VSL 10m
LSUP VSL VIN 1u
CIN VIN 0 470u
VA VAPWR 0 @VAP@
VD VDPWR 0 1.8
VOFF OFF 0 0
VWAKE WAKE 0 0
VRST RSTN 0 PWL(0 0 20u 0 21u 1.8)
XC VAPWR VDPWR 0 SNS_A SNS_B GATE CT OFF WAKE RSTN PWR_ON ILIM FAULT ls_core
XE VIN OUT SNS_A SNS_B GATE CT ext_hw
CL OUT CLE 100u
RCLE CLE 0 30m
RL OUT 0 2
SOV OUT OVL OVC 0 SW1
ROV OVL 0 @RSHORT@
VOVC OVC 0 PWL(0 0 1m 0 1.001m 1)
.model SW1 SW vt=0.5 vh=0.1 ron=1m roff=1e9
.control
tran 1u 3m 0 2u
let iload = i(VSUP)*-1
meas tran m_ipk max iload from=1m to=3m
meas tran m_ilim avg iload from=2.5m to=3m
meas tran m_ipp pp iload from=2.5m to=3m
meas tran m_ct find v(CT) at=2.99m
meas tran m_flag find v(ILIM) at=2.99m
.endc
.end
