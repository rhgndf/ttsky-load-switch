* ls_core: load-switch controller (VAPWR 3.3V analog/control domain, VDPWR 1.8V I/O)
* Pins:
*   SNS_A  divided supply-side shunt node (reference)
*   SNS_B  divided load-side shunt node (feedback)
*   GATE   drive for external NMOS level shifter (which pulls the P-MOSFET gate low)
*   CT     external fault-timer capacitor
*   OFF WAKE RSTN      1.8V digital inputs
*   PWR_ON ILIM FAULT  1.8V digital outputs
.subckt ls_core VAPWR VDPWR VGND SNS_A SNS_B GATE CT OFF WAKE RSTN PWR_ON ILIM FAULT

* ---- bias: ~5uA reference ----
XR1 VAPWR r1 VGND sky130_fd_pr__res_xhigh_po_0p35 L=20
XR2 r1 r2 VGND sky130_fd_pr__res_xhigh_po_0p35 L=20
XR3 r2 r3 VGND sky130_fd_pr__res_xhigh_po_0p35 L=20
XR4 r3 nb VGND sky130_fd_pr__res_xhigh_po_0p35 L=20
XMB0 nb nb VGND VGND sky130_fd_pr__nfet_g5v0d10v5 W=2 L=1
XMB1 pb nb VGND VGND sky130_fd_pr__nfet_g5v0d10v5 W=2 L=1
XMB2 pb pb VAPWR VAPWR sky130_fd_pr__pfet_g5v0d10v5 W=2 L=4

* ---- two-stage error amplifier (GATE rises when SNS_B > SNS_A) ----
XMT tail nb VGND VGND sky130_fd_pr__nfet_g5v0d10v5 W=1 L=1
XM1 d1 SNS_A tail VGND sky130_fd_pr__nfet_g5v0d10v5 W=20 L=2
XM2 out1 SNS_B tail VGND sky130_fd_pr__nfet_g5v0d10v5 W=20 L=2
XM3 d1 d1 VAPWR VAPWR sky130_fd_pr__pfet_g5v0d10v5 W=4 L=2
XM4 out1 d1 VAPWR VAPWR sky130_fd_pr__pfet_g5v0d10v5 W=4 L=2
XM6 GATE out1 VAPWR VAPWR sky130_fd_pr__pfet_g5v0d10v5 W=40 L=1
XM7 GATE nb VGND VGND sky130_fd_pr__nfet_g5v0d10v5 W=40 L=1
XCC out1 cz sky130_fd_pr__cap_mim_m3_1 W=38 L=38 MF=1
XRZ cz GATE VGND sky130_fd_pr__res_xhigh_po_0p35 L=1
* disable: park out1 high, pull GATE low
XMEN out1 en VAPWR VAPWR sky130_fd_pr__pfet_g5v0d10v5 W=2 L=0.5
XMPD GATE enb VGND VGND sky130_fd_pr__nfet_g5v0d10v5 W=5 L=0.5

* ---- saturation detector: det high when amp output is railed high (not limiting) ----
XM6R det out1 VAPWR VAPWR sky130_fd_pr__pfet_g5v0d10v5 W=4 L=1
XM7R det nb VGND VGND sky130_fd_pr__nfet_g5v0d10v5 W=8 L=1

* ---- fault timer ----
XMTS ts pb VAPWR VAPWR sky130_fd_pr__pfet_g5v0d10v5 W=1 L=8
XMTSW CT ilimb_h ts VAPWR sky130_fd_pr__pfet_g5v0d10v5 W=1 L=0.5
XMTD CT ilimb_h VGND VGND sky130_fd_pr__nfet_g5v0d10v5 W=1 L=0.5
XS0 CT VGND VGND VAPWR VAPWR trip sky130_fd_sc_hvl__schmittbuf_1

* ---- input level shifters ----
XLS0 OFF VDPWR VGND VGND VAPWR VAPWR off_h sky130_fd_sc_hvl__lsbuflv2hv_1
XLS1 WAKE VDPWR VGND VGND VAPWR VAPWR wake_h sky130_fd_sc_hvl__lsbuflv2hv_1
XLS2 RSTN VDPWR VGND VGND VAPWR VAPWR rstn_h sky130_fd_sc_hvl__lsbuflv2hv_1
XI0 rstn_h VGND VGND VAPWR VAPWR rst_h sky130_fd_sc_hvl__inv_1

* ---- latches ----
* fault latch: set by trip, cleared by wake/reset
XN0 wake_h rst_h fb VGND VGND VAPWR VAPWR flt sky130_fd_sc_hvl__nor3_1
XN1 trip flt VGND VGND VAPWR VAPWR fb sky130_fd_sc_hvl__nor2_1
* off latch: set by OFF, cleared by wake/reset
XN2 wake_h rst_h oqb VGND VGND VAPWR VAPWR oq sky130_fd_sc_hvl__nor3_1
XN3 off_h oq VGND VGND VAPWR VAPWR oqb sky130_fd_sc_hvl__nor2_1
XN4 oq flt VGND VGND VAPWR VAPWR en sky130_fd_sc_hvl__nor2_1
XI1 en VGND VGND VAPWR VAPWR enb sky130_fd_sc_hvl__inv_1
XN5 det enb VGND VGND VAPWR VAPWR ilim_h sky130_fd_sc_hvl__nor2_1
XI2 ilim_h VGND VGND VAPWR VAPWR ilimb_h sky130_fd_sc_hvl__inv_1

* ---- output level shifters ----
XO0 en VDPWR VGND VGND VAPWR VAPWR PWR_ON sky130_fd_sc_hvl__lsbufhv2lv_1
XO1 ilim_h VDPWR VGND VGND VAPWR VAPWR ILIM sky130_fd_sc_hvl__lsbufhv2lv_1
XO2 flt VDPWR VGND VGND VAPWR VAPWR FAULT sky130_fd_sc_hvl__lsbufhv2lv_1
.ends ls_core
