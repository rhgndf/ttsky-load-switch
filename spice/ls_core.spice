* ls_core: load-switch controller (VAPWR 3.3V analog/control domain, VDPWR 1.8V I/O)
* Pins:
*   SNS_A  divided supply-side shunt node (reference)
*   SNS_B  divided load-side shunt node (feedback)
*   GATE   drive for external NMOS level shifter (which pulls the P-MOSFET gate low)
*   CT     external fault-timer capacitor
*   OFF WAKE RSTN      1.8V digital inputs
*   PWR_ON ILIM FAULT  1.8V digital outputs
* ---- custom 5V-device logic cells (all sky130_fd_pr__*_g5v0d10v5) ----
.subckt ls_inv A Y VPWR VGND
XMP Y A VPWR VPWR sky130_fd_pr__pfet_g5v0d10v5 W=2 L=0.5
XMN Y A VGND VGND sky130_fd_pr__nfet_g5v0d10v5 W=1 L=0.5
.ends ls_inv

.subckt ls_nor2 A B Y VPWR VGND
XMPA pab A VPWR VPWR sky130_fd_pr__pfet_g5v0d10v5 W=2 L=0.5
XMPB Y B pab VPWR sky130_fd_pr__pfet_g5v0d10v5 W=2 L=0.5
XMNA Y A VGND VGND sky130_fd_pr__nfet_g5v0d10v5 W=1 L=0.5
XMNB Y B VGND VGND sky130_fd_pr__nfet_g5v0d10v5 W=1 L=0.5
.ends ls_nor2

.subckt ls_nor3 A B C Y VPWR VGND
XMPA pab A VPWR VPWR sky130_fd_pr__pfet_g5v0d10v5 W=2 L=0.5
XMPB pbc B pab VPWR sky130_fd_pr__pfet_g5v0d10v5 W=2 L=0.5
XMPC Y C pbc VPWR sky130_fd_pr__pfet_g5v0d10v5 W=2 L=0.5
XMNA Y A VGND VGND sky130_fd_pr__nfet_g5v0d10v5 W=1 L=0.5
XMNB Y B VGND VGND sky130_fd_pr__nfet_g5v0d10v5 W=1 L=0.5
XMNC Y C VGND VGND sky130_fd_pr__nfet_g5v0d10v5 W=1 L=0.5
.ends ls_nor3

* 1.8V -> 3.3V: input inverter on VDPWR, then cross-coupled DCVS stage on VAPWR. Y follows A.
.subckt ls_lvshift A Y VAPWR VDPWR VGND
XMPI ab A VDPWR VDPWR sky130_fd_pr__pfet_g5v0d10v5 W=2 L=0.5
XMNI ab A VGND VGND sky130_fd_pr__nfet_g5v0d10v5 W=1 L=0.5
XMNA yb A VGND VGND sky130_fd_pr__nfet_g5v0d10v5 W=4 L=0.5
XMNB Y ab VGND VGND sky130_fd_pr__nfet_g5v0d10v5 W=4 L=0.5
XMPA yb Y VAPWR VAPWR sky130_fd_pr__pfet_g5v0d10v5 W=1 L=1
XMPB Y yb VAPWR VAPWR sky130_fd_pr__pfet_g5v0d10v5 W=1 L=1
.ends ls_lvshift

* non-inverting Schmitt trigger buffer
.subckt ls_schmitt A Y VPWR VGND
XMP1 p1 A VPWR VPWR sky130_fd_pr__pfet_g5v0d10v5 W=1 L=0.5
XMP2 yn A p1 VPWR sky130_fd_pr__pfet_g5v0d10v5 W=1 L=0.5
XMP3 p1 yn VGND VPWR sky130_fd_pr__pfet_g5v0d10v5 W=1 L=0.5
XMN1 n1 A VGND VGND sky130_fd_pr__nfet_g5v0d10v5 W=1 L=0.5
XMN2 yn A n1 VGND sky130_fd_pr__nfet_g5v0d10v5 W=1 L=0.5
XMN3 n1 yn VPWR VGND sky130_fd_pr__nfet_g5v0d10v5 W=1 L=0.5
XMPO Y yn VPWR VPWR sky130_fd_pr__pfet_g5v0d10v5 W=2 L=0.5
XMNO Y yn VGND VGND sky130_fd_pr__nfet_g5v0d10v5 W=1 L=0.5
.ends ls_schmitt

.subckt ls_core VAPWR VDPWR VGND SNS_A SNS_B GATE CT OFF WAKE RSTN PWR_ON ILIM FAULT

* ---- bias: ~5uA reference ----
XR1 VAPWR r1 VGND sky130_fd_pr__res_xhigh_po_0p69 L=40
XR2 r1 r2 VGND sky130_fd_pr__res_xhigh_po_0p69 L=40
XR3 r2 r3 VGND sky130_fd_pr__res_xhigh_po_0p69 L=40
XR4 r3 nb VGND sky130_fd_pr__res_xhigh_po_0p69 L=40
XMB0 nb nb VGND VGND sky130_fd_pr__nfet_g5v0d10v5 W=2 L=1
XMB1 pb nb VGND VGND sky130_fd_pr__nfet_g5v0d10v5 W=2 L=1
XMB2 pb pb VAPWR VAPWR sky130_fd_pr__pfet_g5v0d10v5 W=2 L=4

* ---- two-stage error amplifier (GATE rises when SNS_B > SNS_A) ----
XMT tail nb VGND VGND sky130_fd_pr__nfet_g5v0d10v5 W=1 L=1
XM1 d1 SNS_A tail VGND sky130_fd_pr__nfet_g5v0d10v5 W=20 L=2
XM2 out1 SNS_B tail VGND sky130_fd_pr__nfet_g5v0d10v5 W=20 L=2
XM3 d1 d1 VAPWR VAPWR sky130_fd_pr__pfet_g5v0d10v5 W=4 L=2
XM4 out1 d1 VAPWR VAPWR sky130_fd_pr__pfet_g5v0d10v5 W=4 L=2
XM6 GATE out1 VAPWR VAPWR sky130_fd_pr__pfet_g5v0d10v5 W=40 L=1
XM7 GATE nb VGND VGND sky130_fd_pr__nfet_g5v0d10v5 W=40 L=1
XCC out1 cz sky130_fd_pr__cap_mim_m3_1 W=38 L=38 MF=1
XRZ cz GATE VGND sky130_fd_pr__res_xhigh_po_0p69 L=2
* disable: park out1 high, pull GATE low
XMEN out1 en VAPWR VAPWR sky130_fd_pr__pfet_g5v0d10v5 W=2 L=0.5
XMPD GATE enb VGND VGND sky130_fd_pr__nfet_g5v0d10v5 W=5 L=0.5

* ---- saturation detector: det high when amp output is railed high (not limiting) ----
XM6R det out1 VAPWR VAPWR sky130_fd_pr__pfet_g5v0d10v5 W=4 L=1
XM7R det nb VGND VGND sky130_fd_pr__nfet_g5v0d10v5 W=8 L=1

* ---- fault timer ----
XMTS ts pb VAPWR VAPWR sky130_fd_pr__pfet_g5v0d10v5 W=1 L=8
XMTSW CT ilimb_h ts VAPWR sky130_fd_pr__pfet_g5v0d10v5 W=1 L=0.5
XMTD CT ilimb_h VGND VGND sky130_fd_pr__nfet_g5v0d10v5 W=1 L=0.5
XS0 CT trip VAPWR VGND ls_schmitt

* ---- input level shifters (1.8V -> 3.3V) ----
XLS0 OFF off_h VAPWR VDPWR VGND ls_lvshift
XLS1 WAKE wake_h VAPWR VDPWR VGND ls_lvshift
XLS2 RSTN rstn_h VAPWR VDPWR VGND ls_lvshift
XI0 rstn_h rst_h VAPWR VGND ls_inv

* ---- latches ----
* fault latch: set by trip, cleared by wake/reset
XN0 wake_h rst_h fb flt VAPWR VGND ls_nor3
XN1 trip flt fb VAPWR VGND ls_nor2
* off latch: set by OFF, cleared by wake/reset
XN2 wake_h rst_h oqb oq VAPWR VGND ls_nor3
XN3 off_h oq oqb VAPWR VGND ls_nor2
XN4 oq flt en VAPWR VGND ls_nor2
XI1 en enb VAPWR VGND ls_inv
XN5 det enb ilim_h VAPWR VGND ls_nor2
XI2 ilim_h ilimb_h VAPWR VGND ls_inv
XI3 flt fltb VAPWR VGND ls_inv

* ---- output level shifters (3.3V -> 1.8V): inverters on VDPWR ----
XO0 enb PWR_ON VDPWR VGND ls_inv
XO1 ilimb_h ILIM VDPWR VGND ls_inv
XO2 fltb FAULT VDPWR VGND ls_inv
.ends ls_core
